* CA3140 PSpice Compatible Model
* Date     : 13/03/2024
* Author   : Zabb Csaba
*               3   2  7  4   6   5  1  8
.SUBCKT CA3140 INP INN VP VN OUT O1 O2 STR
Q1  13  14  VP  QINP
Q18 14  14  VP  QINP 6
Q2  12  13  14  QINP
Q3  13  12  11  QINN
R1  11  VN  8k
M1  10  VN  12  12  PIN1
Q19 10  10  VN  QINN1
Q4  15  14  VP  QINP
Q5  16  14  VP  QINP
Q6  17  13  15  QINP
Q7  STR 13  16  QINP
M2  19  INN 17  17  PIN
M3  20  INP 17  17  PIN
CI1 INN 17  4p
CI2 INP 17  4p
D3  9   17  DBE
D4  9   INN DBE
D5  9   INP DBE
R2  19  21  500
R3  20  23  500
Q8  21  19  O1  QINN
Q9  23  19  O2  QINN
R4  O1  VN  500
R5  O2  VN  500
Q10 STR 23  VN  QINN
C1  STR 23  43p
Q11 VP  STR 18  QINN
Q12 18  10  24  QINN
R6  24  VN  50
Q13 OUT 10  VN  QINN
R7  18  25  1K
Q14 22  25  OUT QINN
R8  22  26  20
R9  26  27  1k
Q15 16  27  22  QINN
R10 26  28  50
D6  VP  28  DMODEL
Q16 VP  29  30  QINN
R11 VP  29  40k
R12 30  32  12K
M4  34  18  32  32  PIN2
Q17 OUT 34  VN  QINN1
Q20 34  34  33  QINN1
R13 33  VN  32
R14 31  VN  160k
D8  31  29  DBE
R15 13  VN  1G
D9  VN  VP  DMODEL
.MODEL DBE D(IS=1E-16 N=0.01 BV=6.8 IBV=0.004 RS = 0.1)
.MODEL DMODEL D(IS=1E-14 RS=1E-3)
.MODEL QINN NPN(IS=8E-16 BF=2E3)
.MODEL QINN1 NPN(IS=5E-15 BF=2E3)
.MODEL QINP PNP(IS=8E-16 BF=2E3)
.MODEL PIN1 PMOS(KP=200U VTO=-0.7 L=13U W=60U)
.MODEL PIN PMOS(KP=200U VTO=-0.7 L=3U W=60U)
.MODEL PIN2 PMOS(KP=150U VTO=-1.8 L=1U W=60U)
.ENDS CA3140
*
